* probe B: MODT open circuit
.include lib.inc
.options reltol=1e-9 abstol=1e-15 vntol=1e-12
XM 0 d dn1 dn2 MODT
.control
set numdgt=15
op
print v(d)
quit
.endc
.end
