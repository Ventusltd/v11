* probe C: STRT with default-referencing params
.include lib.inc
.options reltol=1e-9 abstol=1e-15 vntol=1e-12
X1 0 a STRT G1=1000 T1=25 G2=1000 T2=25
.control
set numdgt=15
op
print v(a)
quit
.endc
.end
