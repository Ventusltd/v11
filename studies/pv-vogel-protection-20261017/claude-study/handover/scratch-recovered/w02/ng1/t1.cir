* ngspice diode temperature-law probe
.options reltol=1e-9 abstol=1e-15 vntol=1e-12
.model DT D (IS=3.5e-11 N=22 EG=24.53 XTI=66 TNOM=25)
.model DB D (IS=2.26e-5 N=1.05 RS=0.005 EG=0.69 XTI=2 TNOM=25)
.subckt PROBE a params: G=1000 T=25
I1 0 a DC {G/1000*1.0}
D1 a 0 DT temp={T}
.ends
X25 a25 PROBE G=1000 T=25
Xm10 am10 PROBE G=1000 T=-10
X70 a70 PROBE G=1000 T=70
* bypass diode forward at 17 A at three temps
IB1 0 b25 DC 17
DB1 b25 0 DB temp=25
IB2 0 bm10 DC 17
DB2 bm10 0 DB temp=-10
IB3 0 b70 DC 17
DB3 b70 0 DB temp=70
.control
set wr_singlescale
set wr_vecnames
op
wrdata t1_out.txt v(a25) v(am10) v(a70) v(b25) v(bm10) v(b70)
print v(a25) v(am10) v(a70) v(b25) v(bm10) v(b70)
quit
.endc
.end
