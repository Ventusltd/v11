* plain RLC, check t=0 row, numdgt effect, inductor current
C1 n1 0 150e-6 ic=1143.9
L1 n1 n2 0.6674e-3 ic=0
Vs n2 n3 0
R1 n3 0 2
.tran 1e-6 2e-3 0 1e-6 uic
.options reltol=1e-4 abstol=1e-9 vntol=1e-6 method=gear
.control
set wr_vecnames
run
let hp_v = v(n3)
let hp_i = i(Vs)
let hp_il = i(L1)
wrdata a8.dat hp_v hp_i hp_il
set numdgt=15
wrdata a15.dat hp_v hp_i hp_il
set wr_singlescale
wrdata a15s.dat hp_v hp_i hp_il
print length(hp_v)
quit
.endc
.end
