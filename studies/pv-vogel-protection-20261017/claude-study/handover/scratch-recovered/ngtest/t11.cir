* timestep too small attempt
V1 a 0 PULSE(0 1 1e-6 1e-15 1e-15 1e-6 2e-6)
B1 b 0 V = v(a) > 0.5 ? 1e6 : -1e6
R1 b c 1e-9
C1 c 0 1e-15
L1 c 0 1e-15
.options reltol=1e-9 abstol=1e-18 vntol=1e-15 chgtol=1e-20 trtol=1 maxord=2
.tran 1e-12 1e-5 0 1e-12
.control
run
echo HARNESS_RUN_COMPLETE
quit
.endc
.end
