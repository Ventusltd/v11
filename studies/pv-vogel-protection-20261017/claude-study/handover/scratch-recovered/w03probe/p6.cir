* p6: i(V) local reference in subckt B-source, PWL with subckt params, wrdata after op
.subckt TST a b ctl params: t_trip=1u t_ramp=0.1u kp=10
Vs a m 0
R1 m b 10
Bx b 0 I = max(0, min(5, kp*i(Vs)))*V(ctl)
Vt t 0 PWL(0 0 {t_trip} 0 {t_trip+t_ramp} 1)
Rt t 0 1k
.ends
V1 in 0 10
X1 in o ctl TST t_trip=2u kp=3
Vc ctl 0 1
Ro o 0 1
.control
op
wrdata p6op.txt v(o) i(v.x1.vs) v(x1.t)
tran 10n 5u
wrdata p6tr.txt v(x1.t)
quit
.endc
.end
