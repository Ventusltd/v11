* smoke test of arc_model.lib
.include /home/claude/v11/studies/pv-vogel-protection-20261017/claude-study/models/arc_model.lib
V1 s 0 DC 1144
R1 s a 60
X1 a 0 ARC_SERIES gap_mm=3 i_min=0.5 ignite=1e-4
V2 s2 0 DC -1144
R2 s2 a2 60
X2 a2 0 ARC_SERIES gap_mm=3 i_min=0.5 ignite=1e-4
I3 0 p3 DC 18.4
X3 p3 0 ARC_PARALLEL gap_mm=3 ignite=0
I4 0 p4 DC 18.4
R4 p4 0 5
X4 p4 0 ARC_PARALLEL gap_mm=3 ignite=1e-4 r_series=0
I5 0 p5 DC 18.4
X5 p5 0 ARC_PARALLEL law=1 r_arc=2 ignite=0
.options reltol=1e-6 abstol=1e-12 vntol=1e-9
.control
set wr_singlescale
set wr_vecnames
option numdgt=12
tran 1u 1m
wrdata smoke.out v(a) i(V1) v(a2) i(V2) v(p3) v(p4) v(p5)
.endc
.end
