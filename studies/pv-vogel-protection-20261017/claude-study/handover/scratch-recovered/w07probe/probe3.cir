* probe 3: ln/exp in .param, integrator sign, pwr of negative, wrdata naming
.param lnr = {ln(1e9)}
.param ex = {exp(lnr)}
V1 n1 0 DC -2
B1 o1 0 V = pwr(max(abs(v(n1)),1e-3), 0.5)
R1 o1 0 1
B2 0 e I = 3
C2 e 0 1
R2 e 0 1e12
B3 o3 0 V = {lnr}
R3 o3 0 1
B4 o4 0 V = {ex}
R4 o4 0 1
.control
set wr_singlescale
set wr_vecnames
option numdgt=10
tran 1m 10m
wrdata probe3.out v(o1) v(e) v(o3) v(o4) i(V1)
.endc
.end
