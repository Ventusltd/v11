* RC discharge probe for wrdata format
C1 a 0 150u IC=1143.9
R1 a b 1
Vsense b 0 DC 0
.tran 1u 3m 0 1u uic
.control
run
wrdata rc_pairs.txt v(a) i(vsense)
set wr_vecnames
wrdata rc_pairs_names.txt v(a) i(vsense)
set wr_singlescale
wrdata rc_single_names.txt v(a) i(vsense)
unset wr_vecnames
wrdata rc_single.txt v(a) i(vsense)
quit
.endc
.end
